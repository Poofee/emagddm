# Ansys Electronics Desktop project, version 2024.1
materials:
  B27AV1400_2DSF0.970: permeability{HUnit=A_per_meter BUnit=tesla curve (0, 0) (1.037, 0.0029113001) (1.559, 0.00485196) (2.074, 0.0048526099) (2.594, 0.00776326) (3.111, 0.00873391) (3.63, 0.011644599) (4.656, 0.012615899) (5.182, 0.0135865) (6.214, 0.0184378) (7.244, 0.0213491) (8.286, 0.0242604) (9.321, 0.0281417) (10.358, 0.036873) (15.523, 0.0601595) (20.697, 0.093146) (25.869, 0.14553299) (31.018, 0.216349) (36.155, 0.30753501) (40.846, 0.39484101) (45.865, 0.49960799) (50.917, 0.599524) (61.016, 0.77607699) (71.222, 0.89248999) (81.466, 0.97010007) (91.734, 1.0302599) (102.048, 1.0748899) (149.865, 1.1961999) (201.453, 1.2544601) (252.934, 1.2894499) (304.951, 1.3137601) (356.835, 1.33129) (395.415, 1.3410399) (447.127, 1.3478901) (498.525, 1.3605699) (601.677, 1.3762199) (705.154, 1.3928399) (808.641, 1.4036399) (912.143, 1.4183199) (1015.9, 1.4242699) (2005.43, 1.49244) (3041.99, 1.5393301) (3929.72, 1.5714899) (4961.62, 1.6067301) (8062.97, 1.6979301) (10129.8, 1.74127) (19919.3, 1.87967) (28442.8, 1.9272401) (38692.7, 1.9546701) (48916.8, 1.97334) (59188.8, 1.98916) (79636.8, 2.0158201) (84712.7, 2.0222001) (135471.7, 2.0859997)} conductivity=2000000 core_loss_type="Electrical Steel" core_loss_kh=156.98695 core_loss_kc=0.27355194 mass_density=7420.5
  N45UH_100C_1.251_2DSF1.000_X: permeability=1.0739096 magnetic_coercivity{Magnitude=-927000A_per_meter DirComp1=1 DirComp2=0 DirComp3=0}
  copper_100C: conductivity=58000000
  vacuum: permittivity=1
  Arnold_Magnetics_N42M_120C: permeability{HUnit=A_per_meter BUnit=tesla curve (-418000, -0.5436) (-417000, -0.1084) (-415000, 0.3441) (-408000, 0.5176) (-403000, 0.5588) (-398000, 0.5834) (-393000, 0.6011) (-388000, 0.6151) (-384000, 0.627) (-379000, 0.6376) (-374000, 0.6472) (-369000, 0.6563) (-364000, 0.6648) (-359000, 0.673) (-354000, 0.6809) (-349000, 0.6887) (-344000, 0.6962) (-339000, 0.7036) (-334000, 0.7109) (-329000, 0.7181) (-325000, 0.7252) (-320000, 0.7322) (-315000, 0.7392) (-310000, 0.7461) (-305000, 0.7529) (-300000, 0.7598) (-295000, 0.7666) (-290000, 0.7734) (-285000, 0.7801) (-280000, 0.7868) (-275000, 0.7935) (-270000, 0.8002) (-266000, 0.8068) (-261000, 0.8135) (-256000, 0.8201) (-251000, 0.8267) (-246000, 0.8333) (-241000, 0.8399) (-236000, 0.8465) (-231000, 0.8531) (-226000, 0.8596) (-221000, 0.8662) (-216000, 0.8727) (-211000, 0.8793) (-207000, 0.8858) (-202000, 0.8923) (-197000, 0.8988) (-192000, 0.9053) (-187000, 0.9118) (-182000, 0.9184) (-177000, 0.9249) (-172000, 0.9313) (-167000, 0.9378) (-162000, 0.9443) (-157000, 0.9508) (-152000, 0.9573) (-148000, 0.9638) (-143000, 0.9702) (-138000, 0.9767) (-133000, 0.9832) (-128000, 0.9897) (-123000, 0.9961) (-118000, 1.0026) (-113000, 1.009) (-108000, 1.0155) (-103000, 1.022) (-98000, 1.0284) (-93000, 1.0349) (-89000, 1.0413) (-84000, 1.0478) (-79000, 1.0542) (-74000, 1.0607) (-69000, 1.0671) (-64000, 1.0735) (-59000, 1.08) (-54000, 1.0864) (-49000, 1.0929) (-44000, 1.0993) (-39000, 1.1057) (-34000, 1.1122) (-30000, 1.1186) (-25000, 1.125) (-20000, 1.1315) (-15000, 1.1379) (-10000, 1.1443) (-5000, 1.1508) (0, 1.1572)} conductivity=555555.5556 magnetic_coercivity{Magnitude=-1005300A_per_meter DirComp1=1 DirComp2=0 DirComp3=0}
  JFE Steel - 35JN200: permeability{HUnit=A_per_meter BUnit=tesla curve (0, 0) (20.9479, 0.1) (24.985, 0.2) (29.562, 0.3) (34.773, 0.4) (39.814, 0.5) (45.803, 0.6) (54.254, 0.7) (64.708, 0.8) (76.507, 0.9) (92.92, 1) (118.654, 1.1) (178.081, 1.2) (307.912, 1.3) (701.549, 1.4) (1760.21, 1.5) (3442.31, 1.6) (6875.65, 1.7) (11873.8, 1.8) (30179, 1.9) (60215, 2.0011) (120140, 2.1081) (239710, 2.2743) (478280, 2.582) (954290, 3.1842)}
  copper: permeability=0.999991 conductivity=58000000
  Arnold_Magnetics_N42M_20C: thermal_modifier{Property=permeability free_form_value=1-0.0010876*(Temp-20)} thermal_modifier{Property=magnetic_coercivity free_form_value=1-0.00647*(Temp-20)} permeability{BTypeForSingleCurve=intrinsic HUnit=A_per_meter BUnit=tesla curve (-1170000, -0.05113464) (-1164000, 0.82702554) (-1158000, 1.00308572) (-1142000, 1.14077952) (-1128000, 1.18058661) (-1115000, 1.20295032) (-1101000, 1.2160574) (-1087000, 1.22496449) (-1073000, 1.23157157) (-1060000, 1.23793529) (-1046000, 1.24194237) (-1032000, 1.24514945) (-1018000, 1.24795653) (-1005000, 1.25162025) (-991000, 1.25362733) (-977000, 1.25543441) (-963000, 1.25704149) (-950000, 1.25970521) (-936000, 1.26101229) (-922000, 1.26221937) (-908000, 1.26332645) (-895000, 1.26559017) (-881000, 1.26659725) (-867000, 1.26750433) (-853000, 1.26831141) (-839000, 1.26911849) (-826000, 1.27118221) (-812000, 1.27188929) (-798000, 1.27259638) (-784000, 1.27330346) (-771000, 1.27516717) (-757000, 1.27577426) (-743000, 1.27638134) (-729000, 1.27698842) (-716000, 1.27885214) (-702000, 1.27935922) (-688000, 1.2799663) (-674000, 1.28047338) (-661000, 1.2822371) (-647000, 1.28274418) (-633000, 1.28325126) (-619000, 1.28365834) (-606000, 1.28542206) (-592000, 1.28592914) (-578000, 1.28633622) (-564000, 1.2868433) (-550000, 1.28725038) (-537000, 1.2889141) (-523000, 1.28942118) (-509000, 1.28982826) (-495000, 1.29023535) (-482000, 1.29189906) (-468000, 1.29230614) (-454000, 1.29271323) (-440000, 1.29312031) (-427000, 1.29478403) (-413000, 1.29519111) (-399000, 1.29559819) (-385000, 1.29600527) (-372000, 1.29766899) (-358000, 1.29807607) (-344000, 1.29838315) (-330000, 1.29879023) (-317000, 1.30045395) (-303000, 1.30086103) (-289000, 1.30116811) (-275000, 1.30157519) (-261000, 1.30198227) (-248000, 1.30354599) (-234000, 1.30395307) (-220000, 1.30426015) (-206000, 1.30466723) (-193000, 1.30633095) (-179000, 1.30663803) (-165000, 1.30704512) (-151000, 1.3073522) (-138000, 1.30901591) (-124000, 1.309323) (-110000, 1.30973008) (-96000, 1.31003716) (-83000, 1.31170088) (-69000, 1.31200796) (-55000, 1.31231504) (-41000, 1.31272212) (-28000, 1.31428584) (-14000, 1.31469292) (0, 1.315)} conductivity=555555.5556 magnetic_coercivity{Magnitude=-1169650.5A_per_meter DirComp1=1 DirComp2=0 DirComp3=0}
  Arnold_Magnetics_N42_20C: thermal_modifier{Property=permeability free_form_value=1-0.0010876*(Temp-20)} thermal_modifier{Property=magnetic_coercivity free_form_value=1-0.006474*(Temp-20)} permeability{BTypeForSingleCurve=intrinsic HUnit=A_per_meter BUnit=tesla curve (-1003000, -0.04369303) (-998000, 0.83462379) (-993000, 1.0108406) (-979000, 1.14814768) (-967000, 1.18796804) (-956000, 1.21024503) (-944000, 1.22326539) (-932000, 1.23218574) (-920000, 1.2387061) (-908000, 1.24372645) (-897000, 1.24900344) (-885000, 1.2522238) (-873000, 1.25494415) (-861000, 1.25726451) (-849000, 1.25928487) (-838000, 1.26226186) (-826000, 1.26378221) (-814000, 1.26520257) (-802000, 1.26652292) (-790000, 1.26764328) (-779000, 1.27002027) (-767000, 1.27094063) (-755000, 1.27186098) (-743000, 1.27278134) (-731000, 1.27350169) (-720000, 1.27557868) (-708000, 1.27629904) (-696000, 1.27701939) (-684000, 1.27763975) (-672000, 1.27826011) (-661000, 1.2801371) (-649000, 1.28065745) (-637000, 1.28127781) (-625000, 1.28179816) (-613000, 1.28231852) (-602000, 1.28409551) (-590000, 1.28461587) (-578000, 1.28503622) (-566000, 1.28555658) (-554000, 1.28597693) (-543000, 1.28775392) (-531000, 1.28817428) (-519000, 1.28859463) (-507000, 1.28901499) (-495000, 1.28943535) (-484000, 1.29111234) (-472000, 1.29153269) (-460000, 1.29185305) (-448000, 1.2922734) (-436000, 1.29269376) (-425000, 1.29427075) (-413000, 1.29469111) (-401000, 1.29511146) (-389000, 1.29543182) (-377000, 1.29575217) (-366000, 1.29742916) (-354000, 1.29774952) (-342000, 1.29816988) (-330000, 1.29849023) (-319000, 1.30006722) (-307000, 1.30038758) (-295000, 1.30080793) (-283000, 1.30112829) (-271000, 1.30144864) (-260000, 1.30302564) (-248000, 1.30334599) (-236000, 1.30366635) (-224000, 1.3039867) (-212000, 1.30430706) (-201000, 1.30598405) (-189000, 1.3063044) (-177000, 1.30662476) (-165000, 1.30694512) (-153000, 1.30726547) (-142000, 1.30874246) (-130000, 1.30906282) (-118000, 1.30938317) (-106000, 1.30970353) (-94000, 1.31002388) (-83000, 1.31160088) (-71000, 1.31192123) (-59000, 1.31224159) (-47000, 1.31256194) (-35000, 1.3128823) (-24000, 1.31435929) (-12000, 1.31467964) (0, 1.315)} conductivity=555555.5556 magnetic_coercivity{Magnitude=-1002751.2A_per_meter DirComp1=1 DirComp2=0 DirComp3=0}
  B27AV1400: core_loss_curve{50Hz (0, 0) (0.1, 0.012) (0.2, 0.052) (0.3, 0.109) (0.4, 0.181) (0.5, 0.262) (0.6, 0.354) (0.7, 0.455) (0.75, 0.509) (0.8, 0.566) (0.85, 0.626) (0.9, 0.689) (0.949, 0.755) (0.999, 0.826) (1.049, 0.903) (1.099, 0.984) (1.149, 1.073) (1.199, 1.169) (1.249, 1.276) (1.299, 1.397) (1.319, 1.451) (1.338, 1.506) (1.358, 1.565) (1.379, 1.63) (1.399, 1.695) (1.418, 1.755) (1.439, 1.823) (1.459, 1.886) (1.478, 1.945) (1.499, 1.999) (1.519, 2.052) (1.539, 2.101) (1.559, 2.147) (1.579, 2.189) (1.599, 2.255) (1.617, 2.306) (1.639, 2.329) (1.658, 2.38) (1.678, 2.402) (1.697, 2.45) (1.718, 2.471) (1.738, 2.518) (1.758, 2.541) (1.777, 2.558) (1.798, 2.602) (1.816, 2.618) (1.844, 2.621)} core_loss_curve{100Hz (0, 0) (0.1, 0.027) (0.2, 0.113) (0.3, 0.243) (0.4, 0.403) (0.5, 0.59) (0.599, 0.801) (0.7, 1.035) (0.749, 1.16) (0.799, 1.293) (0.849, 1.433) (0.899, 1.579) (0.949, 1.733) (0.999, 1.898) (1.049, 2.074) (1.099, 2.262) (1.149, 2.465) (1.199, 2.687) (1.249, 2.933) (1.298, 3.211) (1.319, 3.333) (1.338, 3.461) (1.358, 3.597) (1.379, 3.748) (1.4, 3.895) (1.419, 4.042) (1.44, 4.193) (1.46, 4.339) (1.48, 4.475) (1.499, 4.604) (1.519, 4.725) (1.54, 4.834) (1.559, 4.942) (1.579, 5.049) (1.599, 5.178) (1.619, 5.282) (1.64, 5.384) (1.659, 5.484) (1.679, 5.555) (1.699, 5.623) (1.719, 5.72) (1.739, 5.785) (1.757, 5.876) (1.778, 5.936) (1.799, 6.023) (1.818, 6.049) (1.847, 6.133)} core_loss_curve{200Hz (0, 0) (0.1, 0.064) (0.2, 0.266) (0.3, 0.57) (0.4, 0.955) (0.499, 1.408) (0.599, 1.925) (0.7, 2.51) (0.75, 2.823) (0.8, 3.152) (0.85, 3.501) (0.9, 3.867) (0.949, 4.253) (0.999, 4.66) (1.049, 5.1) (1.099, 5.566) (1.149, 6.07) (1.199, 6.614) (1.249, 7.214) (1.299, 7.892) (1.319, 8.189) (1.338, 8.501) (1.359, 8.836) (1.379, 9.186) (1.399, 9.541) (1.418, 9.896) (1.438, 10.257) (1.459, 10.629) (1.478, 10.967) (1.499, 11.278) (1.518, 11.581) (1.539, 11.887) (1.559, 12.157) (1.579, 12.427) (1.599, 12.744) (1.619, 12.977) (1.639, 13.208) (1.659, 13.436) (1.679, 13.662) (1.697, 13.882) (1.717, 14.072) (1.738, 14.291) (1.758, 14.602) (1.798, 14.775) (1.817, 14.986) (1.847, 15.425)} core_loss_curve{400Hz (0, 0) (0.1, 0.161) (0.2, 0.663) (0.3, 1.431) (0.4, 2.416) (0.5, 3.588) (0.6, 4.935) (0.7, 6.462) (0.75, 7.293) (0.8, 8.166) (0.849, 9.096) (0.899, 10.085) (0.949, 11.123) (0.999, 12.231) (1.049, 13.416) (1.099, 14.671) (1.149, 16.024) (1.199, 17.483) (1.249, 19.086) (1.298, 20.87) (1.319, 21.655) (1.339, 22.501) (1.359, 23.395) (1.379, 24.326) (1.399, 25.292) (1.418, 26.301) (1.439, 27.36) (1.459, 28.609) (1.478, 29.681) (1.498, 30.783) (1.518, 31.849) (1.538, 32.94) (1.558, 34.157) (1.578, 35.264)} core_loss_curve{600Hz (0, 0) (0.1, 0.289) (0.2, 1.173) (0.3, 2.532) (0.4, 4.276) (0.5, 6.366) (0.599, 8.785) (0.7, 11.554) (0.749, 13.072) (0.799, 14.69) (0.849, 16.406) (0.899, 18.238) (0.949, 20.188) (0.999, 22.26) (1.049, 24.473) (1.099, 26.834) (1.149, 29.379) (1.199, 32.108) (1.249, 35.103) (1.298, 38.399) (1.318, 39.848) (1.338, 41.402) (1.359, 43.045) (1.378, 44.75) (1.398, 46.536) (1.418, 48.449) (1.438, 50.386) (1.457, 52.648) (1.478, 54.731) (1.498, 56.816) (1.518, 58.903) (1.537, 60.939) (1.558, 63.599) (1.577, 65.651)} core_loss_curve{800Hz (0, 0) (0.1, 0.449) (0.2, 1.798) (0.3, 3.863) (0.4, 6.511) (0.5, 9.696) (0.6, 13.417) (0.699, 17.703) (0.749, 20.075) (0.799, 22.609) (0.849, 25.309) (0.899, 28.204) (0.949, 31.264) (0.998, 34.551) (1.048, 38.082) (1.098, 41.868) (1.148, 45.938) (1.2, 50.651) (1.25, 55.485) (1.3, 60.905) (1.319, 63.375) (1.339, 65.845) (1.359, 68.582) (1.379, 71.53) (1.399, 74.775) (1.419, 78.116) (1.439, 81.708) (1.459, 86.094) (1.479, 90.146) (1.499, 94.255) (1.519, 98.539)} core_loss_curve{1000Hz (0, 0) (0.1, 0.635) (0.2, 2.511) (0.3, 5.372) (0.399, 9.036) (0.5, 13.466) (0.599, 18.67) (0.699, 24.708) (0.749, 28.082) (0.799, 31.697) (0.849, 35.543) (0.898, 39.675) (0.948, 44.111) (1, 49.085) (1.05, 54.213) (1.1, 59.743) (1.15, 65.726) (1.2, 72.22) (1.25, 79.318) (1.299, 87.204) (1.319, 90.755) (1.339, 94.472) (1.359, 98.464) (1.379, 102.676) (1.399, 107.247) (1.419, 112.162) (1.438, 117.306) (1.458, 123.623) (1.478, 129.548) (1.497, 135.534) (1.518, 142)} core_loss_curve{1200Hz (0, 0) (0.1, 0.846) (0.2, 3.311) (0.3, 7.056) (0.4, 11.874) (0.499, 17.705) (0.599, 24.58) (0.699, 32.641) (0.749, 37.147) (0.8, 42.125) (0.85, 47.323) (0.9, 52.909) (0.95, 58.91) (1, 65.394) (1.05, 72.389) (1.1, 79.947) (1.149, 88.077) (1.199, 96.993) (1.249, 106.709) (1.299, 117.513) (1.319, 122.348) (1.338, 127.356) (1.359, 132.823) (1.379, 138.579) (1.398, 144.729) (1.419, 151.51) (1.438, 158.566) (1.457, 167.197) (1.478, 175.483) (1.498, 183.913) (1.518, 192.483)} core_loss_curve{2000Hz (0, 0) (0.1, 1.953) (0.2, 7.413) (0.3, 15.572) (0.399, 26.077) (0.5, 39.135) (0.6, 54.717) (0.699, 73.183) (0.75, 83.637) (0.799, 94.932) (0.85, 107.279) (0.899, 120.578) (0.949, 135.114) (0.999, 150.825) (1.049, 167.912) (1.099, 186.459) (1.149, 206.875) (1.198, 229.013) (1.249, 253.509) (1.298, 281.479) (1.318, 293.913) (1.338, 307.293) (1.358, 320.717) (1.378, 334.739) (1.398, 350.15) (1.417, 366.654) (1.438, 382.134) (1.458, 403.604) (1.477, 423.224) (1.497, 443.215) (1.516, 464.403)} permeability{HUnit=A_per_meter BUnit=tesla curve (0, 0) (1.037, 0.003001303) (1.559, 0.005001959) (2.074, 0.005002606) (2.594, 0.00800326) (3.111, 0.009003909) (3.63, 0.012004562) (4.656, 0.013005851) (5.182, 0.014006512) (6.214, 0.019007809) (7.244, 0.022009103) (8.286, 0.025010412) (9.321, 0.029011713) (10.358, 0.038013016) (15.523, 0.062019507) (20.697, 0.096026009) (25.869, 0.150032508) (31.018, 0.223038978) (36.155, 0.317045434) (40.846, 0.407051329) (45.865, 0.515057636) (50.917, 0.618063984) (61.016, 0.800076675) (71.222, 0.9200895) (81.466, 1.000102373) (91.734, 1.062115276) (102.048, 1.108128237) (149.865, 1.233188326) (201.453, 1.293253153) (252.934, 1.329317846) (304.951, 1.354383213) (356.835, 1.372448412) (395.415, 1.382496893) (447.127, 1.389561876) (498.525, 1.402626465) (601.677, 1.41875609) (705.154, 1.435886123) (808.641, 1.447016168) (912.143, 1.462146233) (1015.904, 1.468276623) (2005.426, 1.538520093) (3041.992, 1.58682268) (3929.721, 1.619938233) (4961.623, 1.656234959) (8062.969, 1.750132225) (10129.772, 1.794729447) (19919.281, 1.937031306) (28442.757, 1.985742222) (38692.665, 2.013622636) (48916.763, 2.032470616) (59188.85, 2.048378901) (79636.787, 2.075074536) (84712.715, 2.081453135)} conductivity=2000000 core_loss_type="Electrical Steel" core_loss_kh=152.27734 core_loss_kc=0.26534538 mass_density=7650 stacking_type=Solid
  N45UH_100C_1.251: permeability=1.0739096 conductivity=555555.5556 magnetic_coercivity{Magnitude=-927kA_per_meter DirComp1=1 DirComp2=0 DirComp3=0}
  copper_20C: conductivity=58000000
  n42inte: permeability=1 conductivity=555555.5556 magnetic_coercivity{Magnitude=-992824 DirComp1=1 DirComp2=0 DirComp3=0}
  Arnold_Magnetics_N42EH_120C: permeability=1 conductivity=555555.5556 magnetic_coercivity{Magnitude=-992824A_per_meter DirComp1=1 DirComp2=0 DirComp3=0}
  Arnold_Magnetics_N42M_120C_gai: permeability{HUnit=A_per_meter BUnit=tesla curve (-416500, 0) (-415000, 0.3441) (-408000, 0.5176) (-403000, 0.5588) (-398000, 0.5834) (-393000, 0.6011) (-388000, 0.6151) (-384000, 0.627) (-379000, 0.6376) (-374000, 0.6472) (-369000, 0.6563) (-364000, 0.6648) (-359000, 0.673) (-354000, 0.6809) (-349000, 0.6887) (-344000, 0.6962) (-339000, 0.7036) (-334000, 0.7109) (-329000, 0.7181) (-325000, 0.7252) (-320000, 0.7322) (-315000, 0.7392) (-310000, 0.7461) (-305000, 0.7529) (-300000, 0.7598) (-295000, 0.7666) (-290000, 0.7734) (-285000, 0.7801) (-280000, 0.7868) (-275000, 0.7935) (-270000, 0.8002) (-266000, 0.8068) (-261000, 0.8135) (-256000, 0.8201) (-251000, 0.8267) (-246000, 0.8333) (-241000, 0.8399) (-236000, 0.8465) (-231000, 0.8531) (-226000, 0.8596) (-221000, 0.8662) (-216000, 0.8727) (-211000, 0.8793) (-207000, 0.8858) (-202000, 0.8923) (-197000, 0.8988) (-192000, 0.9053) (-187000, 0.9118) (-182000, 0.9184) (-177000, 0.9249) (-172000, 0.9313) (-167000, 0.9378) (-162000, 0.9443) (-157000, 0.9508) (-152000, 0.9573) (-148000, 0.9638) (-143000, 0.9702) (-138000, 0.9767) (-133000, 0.9832) (-128000, 0.9897) (-123000, 0.9961) (-118000, 1.0026) (-113000, 1.009) (-108000, 1.0155) (-103000, 1.022) (-98000, 1.0284) (-93000, 1.0349) (-89000, 1.0413) (-84000, 1.0478) (-79000, 1.0542) (-74000, 1.0607) (-69000, 1.0671) (-64000, 1.0735) (-59000, 1.08) (-54000, 1.0864) (-49000, 1.0929) (-44000, 1.0993) (-39000, 1.1057) (-34000, 1.1122) (-30000, 1.1186) (-25000, 1.125) (-20000, 1.1315) (-15000, 1.1379) (-10000, 1.1443) (-5000, 1.1508) (0, 1.1572)} conductivity=555555.5556 magnetic_coercivity{Magnitude=-416500A_per_meter DirComp1=1 DirComp2=0 DirComp3=0}
  Arnold_Magnetics_N42M_20C - Copy: thermal_modifier{Property=magnetic_coercivity free_form_value=1-0.00647*(Temp-20)} permeability{HUnit=A_per_meter BUnit=tesla curve (-1170000, -1.5214) (-1164000, -0.6357) (-1158000, -0.4521) (-1142000, -0.2943) (-1128000, -0.2369) (-1115000, -0.1982) (-1101000, -0.1675) (-1087000, -0.141) (-1073000, -0.1168) (-1060000, -0.0941) (-1046000, -0.0725) (-1032000, -0.0517) (-1018000, -0.0313) (-1005000, -0.0113) (-991000, 0.0083) (-977000, 0.0277) (-963000, 0.0469) (-950000, 0.0659) (-936000, 0.0848) (-922000, 0.1036) (-908000, 0.1223) (-895000, 0.1409) (-881000, 0.1595) (-867000, 0.178) (-853000, 0.1964) (-839000, 0.2148) (-826000, 0.2332) (-812000, 0.2515) (-798000, 0.2698) (-784000, 0.2881) (-771000, 0.3063) (-757000, 0.3245) (-743000, 0.3427) (-729000, 0.3609) (-716000, 0.3791) (-702000, 0.3972) (-688000, 0.4154) (-674000, 0.4335) (-661000, 0.4516) (-647000, 0.4697) (-633000, 0.4878) (-619000, 0.5058) (-606000, 0.5239) (-592000, 0.542) (-578000, 0.56) (-564000, 0.5781) (-550000, 0.5961) (-537000, 0.6141) (-523000, 0.6322) (-509000, 0.6502) (-495000, 0.6682) (-482000, 0.6862) (-468000, 0.7042) (-454000, 0.7222) (-440000, 0.7402) (-427000, 0.7582) (-413000, 0.7762) (-399000, 0.7942) (-385000, 0.8122) (-372000, 0.8302) (-358000, 0.8482) (-344000, 0.8661) (-330000, 0.8841) (-317000, 0.9021) (-303000, 0.9201) (-289000, 0.938) (-275000, 0.956) (-261000, 0.974) (-248000, 0.9919) (-234000, 1.0099) (-220000, 1.0278) (-206000, 1.0458) (-193000, 1.0638) (-179000, 1.0817) (-165000, 1.0997) (-151000, 1.1176) (-138000, 1.1356) (-124000, 1.1535) (-110000, 1.1715) (-96000, 1.1894) (-83000, 1.2074) (-69000, 1.2253) (-55000, 1.2432) (-41000, 1.2612) (-28000, 1.2791) (-14000, 1.2971) (0, 1.315)} conductivity=555555.5556 magnetic_coercivity{Magnitude=-996907.79A_per_meter DirComp1=1 DirComp2=0 DirComp3=0}
  Arnold_Magnetics_N42M_20C_temptable: permeability{HUnit=A_per_meter BUnit=tesla IsTemperatureDependent Temperatures{Temperature{TempRef=20cel} Temperature{TempRef=120cel}} curve (-1170000, -1.5214) (-1164000, -0.6357) (-1158000, -0.4521) (-1142000, -0.2943) (-1128000, -0.2369) (-1115000, -0.1982) (-1101000, -0.1675) (-1087000, -0.141) (-1073000, -0.1168) (-1060000, -0.0941) (-1046000, -0.0725) (-1032000, -0.0517) (-1018000, -0.0313) (-1005000, -0.0113) (-991000, 0.0083) (-977000, 0.0277) (-963000, 0.0469) (-950000, 0.0659) (-936000, 0.0848) (-922000, 0.1036) (-908000, 0.1223) (-895000, 0.1409) (-881000, 0.1595) (-867000, 0.178) (-853000, 0.1964) (-839000, 0.2148) (-826000, 0.2332) (-812000, 0.2515) (-798000, 0.2698) (-784000, 0.2881) (-771000, 0.3063) (-757000, 0.3245) (-743000, 0.3427) (-729000, 0.3609) (-716000, 0.3791) (-702000, 0.3972) (-688000, 0.4154) (-674000, 0.4335) (-661000, 0.4516) (-647000, 0.4697) (-633000, 0.4878) (-619000, 0.5058) (-606000, 0.5239) (-592000, 0.542) (-578000, 0.56) (-564000, 0.5781) (-550000, 0.5961) (-537000, 0.6141) (-523000, 0.6322) (-509000, 0.6502) (-495000, 0.6682) (-482000, 0.6862) (-468000, 0.7042) (-454000, 0.7222) (-440000, 0.7402) (-427000, 0.7582) (-413000, 0.7762) (-399000, 0.7942) (-385000, 0.8122) (-372000, 0.8302) (-358000, 0.8482) (-344000, 0.8661) (-330000, 0.8841) (-317000, 0.9021) (-303000, 0.9201) (-289000, 0.938) (-275000, 0.956) (-261000, 0.974) (-248000, 0.9919) (-234000, 1.0099) (-220000, 1.0278) (-206000, 1.0458) (-193000, 1.0638) (-179000, 1.0817) (-165000, 1.0997) (-151000, 1.1176) (-138000, 1.1356) (-124000, 1.1535) (-110000, 1.1715) (-96000, 1.1894) (-83000, 1.2074) (-69000, 1.2253) (-55000, 1.2432) (-41000, 1.2612) (-28000, 1.2791) (-14000, 1.2971) (0, 1.315)} conductivity=555555.5556 magnetic_coercivity{Magnitude=-996907.79A_per_meter DirComp1=1 DirComp2=0 DirComp3=0}
  Arnold_Magnetics_N42M_20C_temphanshu: thermal_modifier{Property=permeability free_form_value=1-0.0010876*(Temp-20)} thermal_modifier{Property=magnetic_coercivity free_form_value=1-0.006474*(Temp-20)} permeability{BTypeForSingleCurve=intrinsic HUnit=A_per_meter BUnit=tesla Temperatures{Temperature{TempRef=20cel} Temperature{TempRef=120cel}} curve (-1169500, 0) (-1164000, 0.82702554) (-1158000, 1.00308572) (-1142000, 1.14077952) (-1128000, 1.18058661) (-1115000, 1.20295032) (-1101000, 1.2160574) (-1087000, 1.22496449) (-1073000, 1.23157157) (-1060000, 1.23793529) (-1046000, 1.24194237) (-1032000, 1.24514945) (-1018000, 1.24795653) (-1005000, 1.25162025) (-991000, 1.25362733) (-977000, 1.25543441) (-963000, 1.25704149) (-950000, 1.25970521) (-936000, 1.26101229) (-922000, 1.26221937) (-908000, 1.26332645) (-895000, 1.26559017) (-881000, 1.26659725) (-867000, 1.26750433) (-853000, 1.26831141) (-839000, 1.26911849) (-826000, 1.27118221) (-812000, 1.27188929) (-798000, 1.27259638) (-784000, 1.27330346) (-771000, 1.27516717) (-757000, 1.27577426) (-743000, 1.27638134) (-729000, 1.27698842) (-716000, 1.27885214) (-702000, 1.27935922) (-688000, 1.2799663) (-674000, 1.28047338) (-661000, 1.2822371) (-647000, 1.28274418) (-633000, 1.28325126) (-619000, 1.28365834) (-606000, 1.28542206) (-592000, 1.28592914) (-578000, 1.28633622) (-564000, 1.2868433) (-550000, 1.28725038) (-537000, 1.2889141) (-523000, 1.28942118) (-509000, 1.28982826) (-495000, 1.29023535) (-482000, 1.29189906) (-468000, 1.29230614) (-454000, 1.29271323) (-440000, 1.29312031) (-427000, 1.29478403) (-413000, 1.29519111) (-399000, 1.29559819) (-385000, 1.29600527) (-372000, 1.29766899) (-358000, 1.29807607) (-344000, 1.29838315) (-330000, 1.29879023) (-317000, 1.30045395) (-303000, 1.30086103) (-289000, 1.30116811) (-275000, 1.30157519) (-261000, 1.30198227) (-248000, 1.30354599) (-234000, 1.30395307) (-220000, 1.30426015) (-206000, 1.30466723) (-193000, 1.30633095) (-179000, 1.30663803) (-165000, 1.30704512) (-151000, 1.3073522) (-138000, 1.30901591) (-124000, 1.309323) (-110000, 1.30973008) (-96000, 1.31003716) (-83000, 1.31170088) (-69000, 1.31200796) (-55000, 1.31231504) (-41000, 1.31272212) (-28000, 1.31428584) (-14000, 1.31469292) (0, 1.315)} conductivity=555555.5556 magnetic_coercivity{Magnitude=-1169500A_per_meter DirComp1=1 DirComp2=0 DirComp3=0}
  Arnold_Magnetics_N42M_20C_temphanshu - Copy: thermal_modifier{Property=permeability free_form_value=1} thermal_modifier{Property=magnetic_coercivity free_form_value=1} permeability{BTypeForSingleCurve=intrinsic HUnit=A_per_meter BUnit=tesla Temperatures{Temperature{TempRef=20cel} Temperature{TempRef=120cel}} curve (-1169500, 0) (-1164000, 0.82702554) (-1158000, 1.00308572) (-1142000, 1.14077952) (-1128000, 1.18058661) (-1115000, 1.20295032) (-1101000, 1.2160574) (-1087000, 1.22496449) (-1073000, 1.23157157) (-1060000, 1.23793529) (-1046000, 1.24194237) (-1032000, 1.24514945) (-1018000, 1.24795653) (-1005000, 1.25162025) (-991000, 1.25362733) (-977000, 1.25543441) (-963000, 1.25704149) (-950000, 1.25970521) (-936000, 1.26101229) (-922000, 1.26221937) (-908000, 1.26332645) (-895000, 1.26559017) (-881000, 1.26659725) (-867000, 1.26750433) (-853000, 1.26831141) (-839000, 1.26911849) (-826000, 1.27118221) (-812000, 1.27188929) (-798000, 1.27259638) (-784000, 1.27330346) (-771000, 1.27516717) (-757000, 1.27577426) (-743000, 1.27638134) (-729000, 1.27698842) (-716000, 1.27885214) (-702000, 1.27935922) (-688000, 1.2799663) (-674000, 1.28047338) (-661000, 1.2822371) (-647000, 1.28274418) (-633000, 1.28325126) (-619000, 1.28365834) (-606000, 1.28542206) (-592000, 1.28592914) (-578000, 1.28633622) (-564000, 1.2868433) (-550000, 1.28725038) (-537000, 1.2889141) (-523000, 1.28942118) (-509000, 1.28982826) (-495000, 1.29023535) (-482000, 1.29189906) (-468000, 1.29230614) (-454000, 1.29271323) (-440000, 1.29312031) (-427000, 1.29478403) (-413000, 1.29519111) (-399000, 1.29559819) (-385000, 1.29600527) (-372000, 1.29766899) (-358000, 1.29807607) (-344000, 1.29838315) (-330000, 1.29879023) (-317000, 1.30045395) (-303000, 1.30086103) (-289000, 1.30116811) (-275000, 1.30157519) (-261000, 1.30198227) (-248000, 1.30354599) (-234000, 1.30395307) (-220000, 1.30426015) (-206000, 1.30466723) (-193000, 1.30633095) (-179000, 1.30663803) (-165000, 1.30704512) (-151000, 1.3073522) (-138000, 1.30901591) (-124000, 1.309323) (-110000, 1.30973008) (-96000, 1.31003716) (-83000, 1.31170088) (-69000, 1.31200796) (-55000, 1.31231504) (-41000, 1.31272212) (-28000, 1.31428584) (-14000, 1.31469292) (0, 1.315)} conductivity=555555.5556 magnetic_coercivity{Magnitude=-1169500A_per_meter DirComp1=1 DirComp2=0 DirComp3=0}
  Arnold_Magnetics_N42M_20C_temphanshu - Copy (2): thermal_modifier{Property=permeability free_form_value=1} thermal_modifier{Property=magnetic_coercivity free_form_value=0.5} permeability{BTypeForSingleCurve=intrinsic HUnit=A_per_meter BUnit=tesla Temperatures{Temperature{TempRef=20cel} Temperature{TempRef=120cel}} curve (-1169500, 0) (-1164000, 0.82702554) (-1158000, 1.00308572) (-1142000, 1.14077952) (-1128000, 1.18058661) (-1115000, 1.20295032) (-1101000, 1.2160574) (-1087000, 1.22496449) (-1073000, 1.23157157) (-1060000, 1.23793529) (-1046000, 1.24194237) (-1032000, 1.24514945) (-1018000, 1.24795653) (-1005000, 1.25162025) (-991000, 1.25362733) (-977000, 1.25543441) (-963000, 1.25704149) (-950000, 1.25970521) (-936000, 1.26101229) (-922000, 1.26221937) (-908000, 1.26332645) (-895000, 1.26559017) (-881000, 1.26659725) (-867000, 1.26750433) (-853000, 1.26831141) (-839000, 1.26911849) (-826000, 1.27118221) (-812000, 1.27188929) (-798000, 1.27259638) (-784000, 1.27330346) (-771000, 1.27516717) (-757000, 1.27577426) (-743000, 1.27638134) (-729000, 1.27698842) (-716000, 1.27885214) (-702000, 1.27935922) (-688000, 1.2799663) (-674000, 1.28047338) (-661000, 1.2822371) (-647000, 1.28274418) (-633000, 1.28325126) (-619000, 1.28365834) (-606000, 1.28542206) (-592000, 1.28592914) (-578000, 1.28633622) (-564000, 1.2868433) (-550000, 1.28725038) (-537000, 1.2889141) (-523000, 1.28942118) (-509000, 1.28982826) (-495000, 1.29023535) (-482000, 1.29189906) (-468000, 1.29230614) (-454000, 1.29271323) (-440000, 1.29312031) (-427000, 1.29478403) (-413000, 1.29519111) (-399000, 1.29559819) (-385000, 1.29600527) (-372000, 1.29766899) (-358000, 1.29807607) (-344000, 1.29838315) (-330000, 1.29879023) (-317000, 1.30045395) (-303000, 1.30086103) (-289000, 1.30116811) (-275000, 1.30157519) (-261000, 1.30198227) (-248000, 1.30354599) (-234000, 1.30395307) (-220000, 1.30426015) (-206000, 1.30466723) (-193000, 1.30633095) (-179000, 1.30663803) (-165000, 1.30704512) (-151000, 1.3073522) (-138000, 1.30901591) (-124000, 1.309323) (-110000, 1.30973008) (-96000, 1.31003716) (-83000, 1.31170088) (-69000, 1.31200796) (-55000, 1.31231504) (-41000, 1.31272212) (-28000, 1.31428584) (-14000, 1.31469292) (0, 1.315)} conductivity=555555.5556 magnetic_coercivity{Magnitude=-1169500A_per_meter DirComp1=1 DirComp2=0 DirComp3=0}
  Arnold_Magnetics_N42SHX_20C: permeability{HUnit=A_per_meter BUnit=tesla curve (-1671000, -2.1735) (-1663000, -1.2879) (-1654000, -1.1017) (-1632000, -0.9355) (-1612000, -0.8706) (-1593000, -0.8244) (-1573000, -0.7861) (-1553000, -0.7519) (-1534000, -0.7201) (-1514000, -0.6898) (-1494000, -0.6605) (-1475000, -0.6319) (-1455000, -0.6039) (-1435000, -0.5763) (-1416000, -0.549) (-1396000, -0.522) (-1376000, -0.4951) (-1357000, -0.4684) (-1337000, -0.4418) (-1317000, -0.4153) (-1298000, -0.389) (-1278000, -0.3627) (-1258000, -0.3365) (-1239000, -0.3103) (-1219000, -0.2842) (-1199000, -0.2581) (-1180000, -0.2321) (-1160000, -0.2061) (-1140000, -0.1801) (-1121000, -0.1542) (-1101000, -0.1283) (-1081000, -0.1024) (-1062000, -0.0765) (-1042000, -0.0507) (-1022000, -0.0248) (-1003000, 0.001) (-983000, 0.0268) (-963000, 0.0526) (-944000, 0.0784) (-924000, 0.1041) (-904000, 0.1299) (-885000, 0.1556) (-865000, 0.1814) (-845000, 0.2071) (-826000, 0.2328) (-806000, 0.2585) (-786000, 0.2843) (-767000, 0.31) (-747000, 0.3357) (-727000, 0.3613) (-708000, 0.387) (-688000, 0.4127) (-668000, 0.4384) (-649000, 0.4641) (-629000, 0.4897) (-609000, 0.5154) (-590000, 0.5411) (-570000, 0.5667) (-551000, 0.5924) (-531000, 0.6181) (-511000, 0.6437) (-492000, 0.6694) (-472000, 0.695) (-452000, 0.7207) (-433000, 0.7463) (-413000, 0.7719) (-393000, 0.7976) (-374000, 0.8232) (-354000, 0.8488) (-334000, 0.8745) (-315000, 0.9001) (-295000, 0.9257) (-275000, 0.9514) (-256000, 0.977) (-236000, 1.0026) (-216000, 1.0282) (-197000, 1.0539) (-177000, 1.0795) (-157000, 1.1051) (-138000, 1.1307) (-118000, 1.1563) (-98000, 1.1819) (-79000, 1.2076) (-59000, 1.2332) (-39000, 1.2588) (-20000, 1.2844) (0, 1.31)} conductivity=555555.5556 magnetic_coercivity{Magnitude=-1005300A_per_meter DirComp1=1 DirComp2=0 DirComp3=0}
  Arnold_Magnetics_N42SHX_20C - CopygaiBH: permeability{HUnit=A_per_meter BUnit=tesla curve (-758134.5714, -0.9527) (-758021.5714, -0.931263) (-757962.6841, -0.921107) (-757889.4728, -0.909872) (-757834.5644, -0.898639) (-757760.5573, -0.883568) (-757661.8812, -0.864426) (-757541.7193, -0.840566) (-757387.339, -0.811398) (-757195.5573, -0.776765) (-756965.5784, -0.736953) (-756692.6276, -0.692252) (-756369.5431, -0.643214) (-755993.9374, -0.590833) (-755565.8106, -0.536347) (-755087.55, -0.48108) (-754562.3387, -0.426311) (-753994.9513, -0.373171) (-753390.9583, -0.322579) (-752755.1343, -0.2752) (-752092.254, -0.231455) (-751406.2962, -0.191534) (-750701.2398, -0.155446) (-749979.4721, -0.123057) (-749243.3805, -0.094139) (-748494.5565, -0.068404) (-747733.7959, -0.045538) (-746962.6902, -0.025224) (-745800.0633, 0) (-745395.014, 0.00896) (-744600.0351, 0.023376) (-743799.4857, 0.036321) (-742993.3659, 0.047994) (-742182.4715, 0.058562) (-741366.8024, 0.068166) (-740547.9502, 0.076924) (-739725.9149, 0.084935) (-738899.9008, 0.092285) (-738071.4993, 0.099045) (-737240.7105, 0.105278) (-736406.7386, 0.111042) (-735569.5836, 0.116384) (-734730.0413, 0.121348) (-733888.9074, 0.125971) (-733044.5904, 0.130291) (-732198.6819, 0.134336) (-731351.1818, 0.138133) (-730502.886, 0.141707) (-729654.5901, 0.145079) (-728805.4985, 0.148268) (-727955.6111, 0.151292) (-727106.5195, 0.154165) (-726257.4279, 0.156899) (-725408.3362, 0.159507) (-724558.4488, 0.161999) (-723707.7657, 0.164384) (-722856.2867, 0.166669) (-722004.012, 0.168861) (-721150.9415, 0.170968) (-720296.2795, 0.172997) (-719441.6174, 0.174951) (-718585.3638, 0.176839) (-717729.1102, 0.178664) (-716872.8566, 0.180433) (-716015.8073, 0.182151) (-715159.5537, 0.183821) (-714302.5043, 0.185451) (-713446.2507, 0.187041) (-712589.2014, 0.188599) (-711732.152, 0.190126) (-710875.1026, 0.191626) (-710018.0532, 0.193101) (-709160.2081, 0.194555) (-708302.363, 0.195989) (-707443.722, 0.197405) (-706585.0811, 0.198803) (-705725.6444, 0.200186) (-704866.2077, 0.201555) (-704005.9753, 0.202912) (-703145.7428, 0.204257) (-702284.7146, 0.205592) (-701422.8905, 0.20692) (-700561.0665, 0.208238) (-699699.2425, 0.209549) (-698836.6227, 0.210855) (-697973.2072, 0.212154) (-697109.7916, 0.213448) (-696244.7845, 0.214737) (-695379.7774, 0.216021) (-694513.9745, 0.2173) (-693647.3758, 0.218574) (-692779.1856, 0.219845) (-691910.9954, 0.221109) (-691041.2136, 0.22237) (-690170.6361, 0.223626) (-689299.2628, 0.224878) (-688427.8894, 0.226124) (-687555.7204, 0.227367) (-686683.5513, 0.228605) (-685811.3822, 0.229838) (-684939.2131, 0.231069) (-684067.044, 0.232296) (-683195.6707, 0.233519) (-682325.0931, 0.234739) (-681454.5156, 0.235956) (-680586.3254, 0.237168) (-679718.1352, 0.238377) (-678852.3323, 0.239581) (-677987.3252, 0.240782) (-677123.1138, 0.241979) (-676259.6983, 0.243174) (-675397.0785, 0.244366) (-674534.4587, 0.245556) (-673671.0431, 0.246745) (-672807.6276, 0.247934) (-671942.6204, 0.249123) (-671076.0218, 0.250313) (-670207.8316, 0.251505) (-669338.0498, 0.252699) (-668467.4723, 0.253894)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} conductivity=555555.5556 magnetic_coercivity{Magnitude=-745802.06A_per_meter DirComp1=1 DirComp2=0 DirComp3=0}
  Arnold_Magnetics_N42SHX_20C - CopygaiBH - Copy: permeability{HUnit=A_per_meter BUnit=tesla curve (-745800.0633, 0) (-745395.014, 0.00896) (-744600.0351, 0.023376) (-743799.4857, 0.036321) (-742993.3659, 0.047994) (-742182.4715, 0.058562) (-741366.8024, 0.068166) (-740547.9502, 0.076924) (-739725.9149, 0.084935) (-738899.9008, 0.092285) (-738071.4993, 0.099045) (-737240.7105, 0.105278) (-736406.7386, 0.111042) (-735569.5836, 0.116384) (-734730.0413, 0.121348) (-733888.9074, 0.125971) (-733044.5904, 0.130291) (-732198.6819, 0.134336) (-731351.1818, 0.138133) (-730502.886, 0.141707) (-729654.5901, 0.145079) (-728805.4985, 0.148268) (-727955.6111, 0.151292) (-727106.5195, 0.154165) (-726257.4279, 0.156899) (-725408.3362, 0.159507) (-724558.4488, 0.161999) (-723707.7657, 0.164384) (-722856.2867, 0.166669) (-722004.012, 0.168861) (-721150.9415, 0.170968) (-720296.2795, 0.172997) (-719441.6174, 0.174951) (-718585.3638, 0.176839) (-717729.1102, 0.178664) (-716872.8566, 0.180433) (-716015.8073, 0.182151) (-715159.5537, 0.183821) (-714302.5043, 0.185451) (-713446.2507, 0.187041) (-712589.2014, 0.188599) (-711732.152, 0.190126) (-710875.1026, 0.191626) (-710018.0532, 0.193101) (-709160.2081, 0.194555) (-708302.363, 0.195989) (-707443.722, 0.197405) (-706585.0811, 0.198803) (-705725.6444, 0.200186) (-704866.2077, 0.201555) (-704005.9753, 0.202912) (-703145.7428, 0.204257) (-702284.7146, 0.205592) (-701422.8905, 0.20692) (-700561.0665, 0.208238) (-699699.2425, 0.209549) (-698836.6227, 0.210855) (-697973.2072, 0.212154) (-697109.7916, 0.213448) (-696244.7845, 0.214737) (-695379.7774, 0.216021) (-694513.9745, 0.2173) (-693647.3758, 0.218574) (-692779.1856, 0.219845) (-691910.9954, 0.221109) (-691041.2136, 0.22237) (-690170.6361, 0.223626) (-689299.2628, 0.224878) (-688427.8894, 0.226124) (-687555.7204, 0.227367) (-686683.5513, 0.228605) (-685811.3822, 0.229838) (-684939.2131, 0.231069) (-684067.044, 0.232296) (-683195.6707, 0.233519) (-682325.0931, 0.234739) (-681454.5156, 0.235956) (-680586.3254, 0.237168) (-679718.1352, 0.238377) (-678852.3323, 0.239581) (-677987.3252, 0.240782) (-677123.1138, 0.241979) (-676259.6983, 0.243174) (-675397.0785, 0.244366) (-674534.4587, 0.245556) (-673671.0431, 0.246745) (-672807.6276, 0.247934) (-671942.6204, 0.249123) (-671076.0218, 0.250313) (-670207.8316, 0.251505) (-669338.0498, 0.252699) (-668467.4723, 0.253894) (-667594.5074, 0.255091) (-666720.7468, 0.25629) (-665845.3946, 0.25749) (-664970.0424, 0.25869) (-664093.8944, 0.25989) (-663216.9507, 0.26109) (-662340.8027, 0.262288) (-661463.859, 0.263484) (-660587.711, 0.264678) (-659711.5631, 0.26587) (-658835.4151, 0.267059) (-657959.2671, 0.268248) (-657083.915, 0.269433) (-656208.5628, 0.270617) (-655332.4148, 0.2718) (-654457.0626, 0.272981) (-653580.9147, 0.274161) (-652704.7667, 0.27534) (-651827.823, 0.276519) (-650950.8792, 0.277698) (-650073.1397, 0.278877) (-649194.6044, 0.280057) (-648316.0691, 0.281238) (-647435.9423, 0.282421) (-646555.8155, 0.283605) (-645674.0971, 0.284791) (-644792.3787, 0.285978) (-643909.8645, 0.287166)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} conductivity=555555.5556 magnetic_coercivity{Magnitude=-745800.0633A_per_meter DirComp1=1 DirComp2=0 DirComp3=0}

design quan_ID0x45deg_20C3_temp (Maxwell 2D, Transient, XY geometry, model units mm)
options: ComputeTransientInductance ModelDepth=140mm
variables:
  fractions = 1
  delta = 109.9874deg
  conds = 8
  R1 = 0.0052432728ohm
  Le1 = 3.7118689e-06H
  Irms = 500A
  few = 200Hz
  ele_angle = 45deg
  Temp1 = if(Time<0.005s,20, if(Time<0.015s,200,20))
datasets:
  ds1: (0, 0) (0.005, 0) (0.01, 1) (0.015, 1) (0.02, 0) (0.025, 0)
  ds2: (0, 20) (0.005, 20) (0.01, 200) (0.015, 200) (0.02, 20) (0.025, 20)
geometry:
  Band [vacuum] = user_primitive(RMxprt/Band, DiaGap=143.5mm, DiaYoke=60mm, Length=0mm, SegAngle=0deg, Fractions=1, HalfAxial=0, InfoCore=0)
  Shaft [vacuum] = user_primitive(RMxprt/Band, DiaGap=143.5mm, DiaYoke=60mm, Length=0mm, SegAngle=0deg, Fractions=1, HalfAxial=0, InfoCore=100)
  OuterRegion [vacuum] = user_primitive(RMxprt/Band, DiaGap=143.5mm, DiaYoke=220mm, Length=0mm, SegAngle=0deg, Fractions=fractions, HalfAxial=0, InfoCore=100)
  Tool = user_primitive(RMxprt/Band, DiaGap=143.5mm, DiaYoke=220mm, Length=0mm, SegAngle=0deg, Fractions=fractions, HalfAxial=0, InfoCore=1)
  Stator [JFE Steel - 35JN200] = user_primitive(RMxprt/SlotCore, DiaGap=144.2mm, DiaYoke=220mm, Length=0mm, Skew=0deg, Slots=48, SlotType=2, Hs0=0.7mm, Hs01=0mm, Hs1=0.7mm, Hs2=18.5mm, Bs0=2.1mm, Bs1=3.6210127mm, Bs2=6.0461208mm, Rs=3.0230604mm, FilletType=0, HalfSlot=0, SegAngle=15deg, LenRegion=0mm, InfoCore=0)
  Coil_0 [copper_20C] = user_primitive(RMxprt/LapCoil, DiaGap=144.2mm, DiaYoke=220mm, Length=0mm, Skew=0deg, Slots=48, SlotType=2, Hs0=0.7mm, Hs1=0.7mm, Hs2=18.5mm, Bs0=2.1mm, Bs1=3.6210127mm, Bs2=6.0461208mm, Rs=3.0230604mm, FilletType=0, Layers=1, CoilPitch=2, EndExt=5mm, SpanExt=0mm, BendAngle=0deg, SegAngle=10deg, LenRegion=0mm, InfoCoil=2)
  Coil_1..Coil_47 [copper_20C] = Coil_0.duplicate_around_axis(axis=Z, angle=7.5deg, total=48)
  Rotor [JFE Steel - 35JN200] = user_primitive(RMxprt/IPMCore, DiaGap=142.8mm, DiaYoke=60mm, Length=0mm, Poles=8, PoleType=3, D1=140.8mm, O1=1mm, O2=28mm, B1=3.2mm, Rib=15mm, HRib=2.5mm, DminMag=0mm, ThickMag=4mm, WidthMag=30mm, LenRegion=0mm, InfoCore=0)
  Rotor.rotate(axis=Z, angle=22.5deg)
  coordinate_system relativeCS1_0 = origin=(0, 0, 0) x=(0.99983504, 0.01816294, 0) y=(-0.01816294, 0.99983504, 0)
  Mag1_0 [Arnold_Magnetics_N42M_20C_temptable, oriented by relativeCS1_0] = user_primitive(RMxprt/IPMCore, DiaGap=142.8mm, DiaYoke=60mm, Length=0mm, Poles=8, PoleType=3, D1=140.8mm, O1=1mm, O2=28mm, B1=3.2mm, Rib=15mm, HRib=2.5mm, DminMag=0mm, ThickMag=4mm, WidthMag=30mm, LenRegion=0mm, InfoCore=-1)
  Mag1_0.rotate(axis=Z, angle=22.5deg)
  Mag1_1 [Arnold_Magnetics_N42M_20C_temptable, oriented by relativeCS1_1], Mag1_2 [Arnold_Magnetics_N42M_20C_temptable, oriented by relativeCS1_2], Mag1_3 [Arnold_Magnetics_N42M_20C_temptable, oriented by relativeCS1_3], Mag1_4 [Arnold_Magnetics_N42M_20C_temptable, oriented by relativeCS1_4], Mag1_5 [Arnold_Magnetics_N42M_20C_temptable, oriented by relativeCS1_5], Mag1_6 [Arnold_Magnetics_N42M_20C_temptable, oriented by relativeCS1_6], Mag1_7 [Arnold_Magnetics_N42M_20C_temptable, oriented by relativeCS1_7] = Mag1_0.duplicate_around_axis(axis=Z, angle=45deg, total=8)
  coordinate_system relativeCS1_1 = origin=(0, 0, 0) x=(-0.694147, -0.71983327, 0) y=(0.71983327, -0.694147, 0)
  coordinate_system relativeCS1_2 = origin=(0, 0, 0) x=(-0.01816294, 0.99983504, 0) y=(-0.99983504, -0.01816294, 0)
  coordinate_system relativeCS1_3 = origin=(0, 0, 0) x=(0.71983327, -0.694147, 0) y=(0.694147, 0.71983327, 0)
  coordinate_system relativeCS1_4 = origin=(0, 0, 0) x=(-0.99983504, -0.01816294, 0) y=(0.01816294, -0.99983504, 0)
  coordinate_system relativeCS1_5 = origin=(0, 0, 0) x=(0.694147, 0.71983327, 0) y=(-0.71983327, 0.694147, 0)
  coordinate_system relativeCS1_6 = origin=(0, 0, 0) x=(0.01816294, -0.99983504, 0) y=(0.99983504, 0.01816294, 0)
  coordinate_system relativeCS1_7 = origin=(0, 0, 0) x=(-0.71983327, 0.694147, 0) y=(-0.694147, -0.71983327, 0)
  coordinate_system relativeCS2_0 = origin=(0, 0, 0) x=(0.71983327, 0.694147, 0) y=(-0.694147, 0.71983327, 0)
  Mag2_0 [Arnold_Magnetics_N42M_20C_temptable, oriented by relativeCS2_0] = user_primitive(RMxprt/IPMCore, DiaGap=142.8mm, DiaYoke=60mm, Length=0mm, Poles=8, PoleType=3, D1=140.8mm, O1=1mm, O2=28mm, B1=3.2mm, Rib=15mm, HRib=2.5mm, DminMag=0mm, ThickMag=4mm, WidthMag=30mm, LenRegion=0mm, InfoCore=-2)
  Mag2_0.rotate(axis=Z, angle=22.5deg)
  Mag2_1 [Arnold_Magnetics_N42M_20C_temptable, oriented by relativeCS2_1], Mag2_2 [Arnold_Magnetics_N42M_20C_temptable, oriented by relativeCS2_2], Mag2_3 [Arnold_Magnetics_N42M_20C_temptable, oriented by relativeCS2_3], Mag2_4 [Arnold_Magnetics_N42M_20C_temptable, oriented by relativeCS2_4], Mag2_5 [Arnold_Magnetics_N42M_20C_temptable, oriented by relativeCS2_5], Mag2_6 [Arnold_Magnetics_N42M_20C_temptable, oriented by relativeCS2_6], Mag2_7 [Arnold_Magnetics_N42M_20C_temptable, oriented by relativeCS2_7] = Mag2_0.duplicate_around_axis(axis=Z, angle=45deg, total=8)
  coordinate_system relativeCS2_1 = origin=(0, 0, 0) x=(-0.01816294, -0.99983504, 0) y=(0.99983504, -0.01816294, 0)
  coordinate_system relativeCS2_2 = origin=(0, 0, 0) x=(-0.694147, 0.71983327, 0) y=(-0.71983327, -0.694147, 0)
  coordinate_system relativeCS2_3 = origin=(0, 0, 0) x=(0.99983504, -0.01816294, 0) y=(0.01816294, 0.99983504, 0)
  coordinate_system relativeCS2_4 = origin=(0, 0, 0) x=(-0.71983327, -0.694147, 0) y=(0.694147, -0.71983327, 0)
  coordinate_system relativeCS2_5 = origin=(0, 0, 0) x=(0.01816294, 0.99983504, 0) y=(-0.99983504, 0.01816294, 0)
  coordinate_system relativeCS2_6 = origin=(0, 0, 0) x=(0.694147, -0.71983327, 0) y=(0.71983327, 0.694147, 0)
  coordinate_system relativeCS2_7 = origin=(0, 0, 0) x=(-0.99983504, 0.01816294, 0) y=(-0.01816294, -0.99983504, 0)
  InnerRegion [vacuum] = user_primitive(RMxprt/IPMCore, DiaGap=142.8mm, DiaYoke=60mm, Length=0mm, Poles=8, PoleType=3, D1=140.8mm, O1=1mm, O2=28mm, B1=3.2mm, Rib=15mm, HRib=2.5mm, DminMag=0mm, ThickMag=4mm, WidthMag=30mm, LenRegion=0mm, InfoCore=100)
  InnerRegion.rotate(axis=Z, angle=22.5deg)
  Tool_1 = Tool.copy()
  Band.subtract(Tool_1)
  Tool_2 = Tool.copy()
  InnerRegion.subtract(Tool_2)
  Tool_3 = Tool.copy()
  Shaft.subtract(Tool_3)
  Tool_4 = Tool.copy()
  Stator.subtract(Tool_4)
  Tool_5 = Tool.copy()
  Coil_0.subtract(Tool_5)
  Tool_6 = Tool.copy()
  Coil_1.subtract(Tool_6)
  Tool_7 = Tool.copy()
  Coil_2.subtract(Tool_7)
  Tool_8 = Tool.copy()
  Coil_3.subtract(Tool_8)
  Tool_9 = Tool.copy()
  Coil_4.subtract(Tool_9)
  Tool_10 = Tool.copy()
  Coil_5.subtract(Tool_10)
  Tool_11 = Tool.copy()
  Coil_6.subtract(Tool_11)
  Tool_12 = Tool.copy()
  Coil_7.subtract(Tool_12)
  Tool_13 = Tool.copy()
  Coil_8.subtract(Tool_13)
  Tool_14 = Tool.copy()
  Coil_9.subtract(Tool_14)
  Tool_15 = Tool.copy()
  Coil_10.subtract(Tool_15)
  Tool_16 = Tool.copy()
  Coil_11.subtract(Tool_16)
  Tool_17 = Tool.copy()
  Coil_12.subtract(Tool_17)
  Tool_18 = Tool.copy()
  Coil_13.subtract(Tool_18)
  Tool_19 = Tool.copy()
  Coil_14.subtract(Tool_19)
  Tool_20 = Tool.copy()
  Coil_15.subtract(Tool_20)
  Tool_21 = Tool.copy()
  Coil_16.subtract(Tool_21)
  Tool_22 = Tool.copy()
  Coil_17.subtract(Tool_22)
  Tool_23 = Tool.copy()
  Coil_18.subtract(Tool_23)
  Tool_24 = Tool.copy()
  Coil_19.subtract(Tool_24)
  Tool_25 = Tool.copy()
  Coil_20.subtract(Tool_25)
  Tool_26 = Tool.copy()
  Coil_21.subtract(Tool_26)
  Tool_27 = Tool.copy()
  Coil_22.subtract(Tool_27)
  Tool_28 = Tool.copy()
  Coil_23.subtract(Tool_28)
  Tool_29 = Tool.copy()
  Coil_24.subtract(Tool_29)
  Tool_30 = Tool.copy()
  Coil_25.subtract(Tool_30)
  Tool_31 = Tool.copy()
  Coil_26.subtract(Tool_31)
  Tool_32 = Tool.copy()
  Coil_27.subtract(Tool_32)
  Tool_33 = Tool.copy()
  Coil_28.subtract(Tool_33)
  Tool_34 = Tool.copy()
  Coil_29.subtract(Tool_34)
  Tool_35 = Tool.copy()
  Coil_30.subtract(Tool_35)
  Tool_36 = Tool.copy()
  Coil_31.subtract(Tool_36)
  Tool_37 = Tool.copy()
  Coil_32.subtract(Tool_37)
  Tool_38 = Tool.copy()
  Coil_33.subtract(Tool_38)
  Tool_39 = Tool.copy()
  Coil_34.subtract(Tool_39)
  Tool_40 = Tool.copy()
  Coil_35.subtract(Tool_40)
  Tool_41 = Tool.copy()
  Coil_36.subtract(Tool_41)
  Tool_42 = Tool.copy()
  Coil_37.subtract(Tool_42)
  Tool_43 = Tool.copy()
  Coil_38.subtract(Tool_43)
  Tool_44 = Tool.copy()
  Coil_39.subtract(Tool_44)
  Tool_45 = Tool.copy()
  Coil_40.subtract(Tool_45)
  Tool_46 = Tool.copy()
  Coil_41.subtract(Tool_46)
  Tool_47 = Tool.copy()
  Coil_42.subtract(Tool_47)
  Tool_48 = Tool.copy()
  Coil_43.subtract(Tool_48)
  Tool_49 = Tool.copy()
  Coil_44.subtract(Tool_49)
  Tool_50 = Tool.copy()
  Coil_45.subtract(Tool_50)
  Tool_51 = Tool.copy()
  Coil_46.subtract(Tool_51)
  Tool_52 = Tool.copy()
  Coil_47.subtract(Tool_52)
  Tool_53 = Tool.copy()
  Rotor.subtract(Tool_53)
  Tool_54 = Tool.copy()
  Mag1_0.subtract(Tool_54)
  Tool_55 = Tool.copy()
  Mag1_1.subtract(Tool_55)
  Tool_56 = Tool.copy()
  Mag1_2.subtract(Tool_56)
  Tool_57 = Tool.copy()
  Mag1_3.subtract(Tool_57)
  Tool_58 = Tool.copy()
  Mag1_4.subtract(Tool_58)
  Tool_59 = Tool.copy()
  Mag1_5.subtract(Tool_59)
  Tool_60 = Tool.copy()
  Mag1_6.subtract(Tool_60)
  Tool_61 = Tool.copy()
  Mag1_7.subtract(Tool_61)
  Tool_62 = Tool.copy()
  Mag2_0.subtract(Tool_62)
  Tool_63 = Tool.copy()
  Mag2_1.subtract(Tool_63)
  Tool_64 = Tool.copy()
  Mag2_2.subtract(Tool_64)
  Tool_65 = Tool.copy()
  Mag2_3.subtract(Tool_65)
  Tool_66 = Tool.copy()
  Mag2_4.subtract(Tool_66)
  Tool_67 = Tool.copy()
  Mag2_5.subtract(Tool_67)
  Tool_68 = Tool.copy()
  Mag2_6.subtract(Tool_68)
  Mag2_7.subtract(Tool)
  Polyline1 [non-model] = polyline((1.4365508mm, -11.154511mm, 0mm) (2.9011954mm, -9.7925942mm, 0mm)) in FaceCS2
  Polyline1.move(0.99983504mm, 0.01816294mm, 0mm)
  Polyline1.move(-0.13622205mm, 7.4987628mm, 0mm)
  Tool1 = user_primitive(RMxprt/Band, DiaGap=143.5mm, DiaYoke=220mm, Length=0mm, SegAngle=0deg, Fractions=fractions, HalfAxial=0, InfoCore=1)
  Mag2_01 = user_primitive(RMxprt/IPMCore, DiaGap=142.8mm, DiaYoke=60mm, Length=0mm, Poles=8, PoleType=3, D1=140.8mm, O1=1mm, O2=28mm, B1=3.2mm, Rib=15mm, HRib=2.5mm, DminMag=0mm, ThickMag=4mm, WidthMag=30mm, LenRegion=0mm, InfoCore=-2)
  Mag2_01.rotate(axis=Z, angle=22.5deg)
  Mag2_8..Mag2_14 = Mag2_01.duplicate_around_axis(axis=Z, angle=45deg, total=8)
  Mag2_01.unite(Mag2_8..Mag2_14)
  Mag2_01.subtract(Tool1)
  Mag2_01.delete()
  coordinate_system FaceCS2 = face of Mag2_01: Origin=(59.277758, 14.873338, 0) FaceID=Mag2_01.face(1 of 1) AxisPosn=(62.157091, 17.649926, 0) WhichAxis=X ZRotationAngle=0deg XOffset=0mm YOffset=0mm FaceNormal(0, 0, -1)
motion:
  MotionSetup1: Band Move_Type=Rotate Coordinate_System=Global Axis=Z Is_Positive=true InitPos=7.5deg Angular_Velocity=3000rpm Objects=Band
  Moving1: Moving Objects=[Polyline1, Shaft, Rotor, Mag1_0..Mag1_7, Mag2_0..Mag2_7, InnerRegion]
boundaries and excitations:
  VectorPotential1: Vector Potential Edges=OuterRegion.edge(at (0, -110, 0)) Value=0
  PhARe_0: Coil Objects=Coil_43 Conductor_number=conds Winding=PhaseA PolarityType=Negative
  PhA_0: Coil Objects=Coil_0 Conductor_number=conds Winding=PhaseA PolarityType=Positive
  PhA_1: Coil Objects=Coil_1 Conductor_number=conds Winding=PhaseA PolarityType=Positive
  PhARe_1: Coil Objects=Coil_6 Conductor_number=conds Winding=PhaseA PolarityType=Negative
  PhBRe_2: Coil Objects=Coil_47 Conductor_number=conds Winding=PhaseB PolarityType=Negative
  PhB_2: Coil Objects=Coil_4 Conductor_number=conds Winding=PhaseB PolarityType=Positive
  PhB_3: Coil Objects=Coil_5 Conductor_number=conds Winding=PhaseB PolarityType=Positive
  PhBRe_3: Coil Objects=Coil_10 Conductor_number=conds Winding=PhaseB PolarityType=Negative
  PhCRe_4: Coil Objects=Coil_3 Conductor_number=conds Winding=PhaseC PolarityType=Negative
  PhC_4: Coil Objects=Coil_8 Conductor_number=conds Winding=PhaseC PolarityType=Positive
  PhC_5: Coil Objects=Coil_9 Conductor_number=conds Winding=PhaseC PolarityType=Positive
  PhCRe_5: Coil Objects=Coil_14 Conductor_number=conds Winding=PhaseC PolarityType=Negative
  PhARe_6: Coil Objects=Coil_7 Conductor_number=conds Winding=PhaseA PolarityType=Negative
  PhA_6: Coil Objects=Coil_12 Conductor_number=conds Winding=PhaseA PolarityType=Positive
  PhA_7: Coil Objects=Coil_13 Conductor_number=conds Winding=PhaseA PolarityType=Positive
  PhARe_7: Coil Objects=Coil_18 Conductor_number=conds Winding=PhaseA PolarityType=Negative
  PhBRe_8: Coil Objects=Coil_11 Conductor_number=conds Winding=PhaseB PolarityType=Negative
  PhB_8: Coil Objects=Coil_16 Conductor_number=conds Winding=PhaseB PolarityType=Positive
  PhB_9: Coil Objects=Coil_17 Conductor_number=conds Winding=PhaseB PolarityType=Positive
  PhBRe_9: Coil Objects=Coil_22 Conductor_number=conds Winding=PhaseB PolarityType=Negative
  PhCRe_10: Coil Objects=Coil_15 Conductor_number=conds Winding=PhaseC PolarityType=Negative
  PhC_10: Coil Objects=Coil_20 Conductor_number=conds Winding=PhaseC PolarityType=Positive
  PhC_11: Coil Objects=Coil_21 Conductor_number=conds Winding=PhaseC PolarityType=Positive
  PhCRe_11: Coil Objects=Coil_26 Conductor_number=conds Winding=PhaseC PolarityType=Negative
  PhARe_12: Coil Objects=Coil_19 Conductor_number=conds Winding=PhaseA PolarityType=Negative
  PhA_12: Coil Objects=Coil_24 Conductor_number=conds Winding=PhaseA PolarityType=Positive
  PhA_13: Coil Objects=Coil_25 Conductor_number=conds Winding=PhaseA PolarityType=Positive
  PhARe_13: Coil Objects=Coil_30 Conductor_number=conds Winding=PhaseA PolarityType=Negative
  PhBRe_14: Coil Objects=Coil_23 Conductor_number=conds Winding=PhaseB PolarityType=Negative
  PhB_14: Coil Objects=Coil_28 Conductor_number=conds Winding=PhaseB PolarityType=Positive
  PhB_15: Coil Objects=Coil_29 Conductor_number=conds Winding=PhaseB PolarityType=Positive
  PhBRe_15: Coil Objects=Coil_34 Conductor_number=conds Winding=PhaseB PolarityType=Negative
  PhCRe_16: Coil Objects=Coil_27 Conductor_number=conds Winding=PhaseC PolarityType=Negative
  PhC_16: Coil Objects=Coil_32 Conductor_number=conds Winding=PhaseC PolarityType=Positive
  PhC_17: Coil Objects=Coil_33 Conductor_number=conds Winding=PhaseC PolarityType=Positive
  PhCRe_17: Coil Objects=Coil_38 Conductor_number=conds Winding=PhaseC PolarityType=Negative
  PhARe_18: Coil Objects=Coil_31 Conductor_number=conds Winding=PhaseA PolarityType=Negative
  PhA_18: Coil Objects=Coil_36 Conductor_number=conds Winding=PhaseA PolarityType=Positive
  PhA_19: Coil Objects=Coil_37 Conductor_number=conds Winding=PhaseA PolarityType=Positive
  PhARe_19: Coil Objects=Coil_42 Conductor_number=conds Winding=PhaseA PolarityType=Negative
  PhBRe_20: Coil Objects=Coil_35 Conductor_number=conds Winding=PhaseB PolarityType=Negative
  PhB_20: Coil Objects=Coil_40 Conductor_number=conds Winding=PhaseB PolarityType=Positive
  PhB_21: Coil Objects=Coil_41 Conductor_number=conds Winding=PhaseB PolarityType=Positive
  PhBRe_21: Coil Objects=Coil_46 Conductor_number=conds Winding=PhaseB PolarityType=Negative
  PhCRe_22: Coil Objects=Coil_39 Conductor_number=conds Winding=PhaseC PolarityType=Negative
  PhC_22: Coil Objects=Coil_44 Conductor_number=conds Winding=PhaseC PolarityType=Positive
  PhC_23: Coil Objects=Coil_45 Conductor_number=conds Winding=PhaseC PolarityType=Positive
  PhCRe_23: Coil Objects=Coil_2 Conductor_number=conds Winding=PhaseC PolarityType=Negative
  PhaseA: Winding Group Type=Current IsSolid=false Current=Irms*sqrt(2)*sin(2*pi*few*time+ele_angle) ParallelBranchesNum=4
  PhaseB: Winding Group Type=Current IsSolid=false Current=Irms*sqrt(2)*sin(2*pi*few*time+ele_angle-2/3*pi) ParallelBranchesNum=4
  PhaseC: Winding Group Type=Current IsSolid=false Current=Irms*sqrt(2)*sin(2*pi*few*time+ele_angle-4/3*pi) ParallelBranchesNum=4
mesh:
  SurfApprox1: SurfApproxBased Objects=[Band, Shaft, OuterRegion, Stator, Coil_0..Coil_47, Rotor, Mag1_0..Mag1_7, Mag2_0..Mag2_7, InnerRegion] CurvedSurfaceApproxChoice=ManualSettings SurfDev=0.15mm NormalDev=30deg
  M: LengthBased RefineInside Objects=[Mag1_0..Mag1_7, Mag2_0..Mag2_7] MaxLength=1mm
  C: LengthBased RefineInside Objects=[Coil_0..Coil_47] MaxLength=1mm
  R: LengthBased RefineInside Objects=Rotor MaxLength=4mm
  S: LengthBased RefineInside Objects=Stator MaxLength=5mm
  CylindricalGap1: CylindricalGap Objects=Band Objects=Band
temperatures:
  Band, Shaft, OuterRegion, Stator, Coil_0..Coil_47, Rotor, InnerRegion: 22cel
  Mag1_0..Mag1_7, Mag2_0..Mag2_7: Temp1
setups:
  Setup1: Transient NonlinearSolverResidual=0.0001 StopTime=0.025s TimeStep=0.0001s OutputPerObjectCoreLoss FastReachSteadyState AutoDetectSteadyState FrequencyOfAddedVoltageSource=308.06667Hz StopCriterion=0.005 SaveFieldsType="Every N Steps" N_Steps=1 Steps_From=0s Steps_To=0.025s NumberSolveSteps=1 RangeStart=0s RangeEnd=0.1s InitialTimeStep=0.002s MinTimeStep=0.001s MaxTimeStep=0.003s TimeStepErrTolerance=0.0001
output variables:
  pos = (Moving1.Position -7.5 * PI/180) * 4 + PI
  cos0 = cos(pos)
  cos1 = cos(pos-2*PI/3)
  cos2 = cos(pos-4*PI/3)
  sin0 = sin(pos)
  sin1 = sin(pos-2*PI/3)
  sin2 = sin(pos-4*PI/3)
  Lad = L(PhaseA,PhaseA)*cos0 + L(PhaseA,PhaseB)*cos1 + L(PhaseA,PhaseC)*cos2
  Laq = L(PhaseA,PhaseA)*sin0 + L(PhaseA,PhaseB)*sin1 + L(PhaseA,PhaseC)*sin2
  Lbd = L(PhaseB,PhaseA)*cos0 + L(PhaseB,PhaseB)*cos1 + L(PhaseB,PhaseC)*cos2
  Lbq = L(PhaseB,PhaseA)*sin0 + L(PhaseB,PhaseB)*sin1 + L(PhaseB,PhaseC)*sin2
  Lcd = L(PhaseC,PhaseA)*cos0 + L(PhaseC,PhaseB)*cos1 + L(PhaseC,PhaseC)*cos2
  Lcq = L(PhaseC,PhaseA)*sin0 + L(PhaseC,PhaseB)*sin1 + L(PhaseC,PhaseC)*sin2
  L_d = (Lad*cos0 + Lbd*cos1 + Lcd*cos2) * 2/3
  L_q = (Laq*sin0 + Lbq*sin1 + Lcq*sin2) * 2/3
  Flux_d = (FluxLinkage(PhaseA)*cos0+FluxLinkage(PhaseB)*cos1+FluxLinkage(PhaseC)*cos2)*2/3
  Flux_q = (FluxLinkage(PhaseA)*sin0+FluxLinkage(PhaseB)*sin1+FluxLinkage(PhaseC)*sin2)*2/3
  I_d = (Current(PhaseA)*cos0 + Current(PhaseB)*cos1 + Current(PhaseC)*cos2)*2/3
  I_q = (Current(PhaseA)*sin0 + Current(PhaseB)*sin1 + Current(PhaseC)*sin2)*2/3
  Irms = sqrt(I_d^2+I_q^2)/sqrt(2)
  Pcu = 3*Irms^2*R1
field calculator expressions:
  Bt1 = Fundamental_Quantity(22) | Tangent | Dot | EnterLine(Polyline1) | LineValue | Integrate | 1 | EnterLine(Polyline1) | LineValue | Integrate | /
  Ht1 = Fundamental_Quantity(21) | Tangent | Dot | EnterLine(Polyline1) | LineValue | Integrate | 1 | EnterLine(Polyline1) | LineValue | Integrate | /
field plots:
  Mag_B1: B over Mag1_0..Mag1_7, Mag2_0..Mag2_7 on Setup1 : Transient at Time=0.022s
reports:
  Torque: Moving1.Torque vs Time on Setup1 : Transient
  Winding Plot 3: InducedVoltage(PhaseA) vs Time on Setup1 : Transient
